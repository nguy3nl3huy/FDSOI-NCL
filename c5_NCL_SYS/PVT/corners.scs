// ------------------------------------------------------
// Mismatch Variations Selection
// ------------------------------------------------------
parameters cmom_5u1x_2t8x_lb_dev=0
parameters cmom_5u1x_2t8x_lb_wo_via_dev=0
parameters cmom_6u1x_2t8x_lb_dev=0
parameters cmom_6u1x_2t8x_lb_wo_via_dev=0
parameters cmom_6u1x_2u2x_2t8x_lb_dev=0
parameters cmom_6u1x_2u2x_2t8x_lb_wo_via_dev=0
parameters cmom_5u1x_1t8x_lb_dev=0
parameters cmom_5u1x_1t8x_lb_wo_via_dev=0
parameters driftotp_dev=0
parameters cvar_eg_dev=0
parameters pnpv_dev=0
parameters npnv_dev=0
parameters ind_lohq_5U1x_2T8x_LB_dev=0
parameters ind_hq_5U1x_2T8x_LB_dev=0
parameters ind_lohq_6U1x_2T8x_LB_dev=0
parameters ind_hq_6U1x_2T8x_LB_dev=0
parameters ind_lohq_6U1x_2U2x_2T8x_LB_dev=0
parameters ind_hq_6U1x_2U2x_2T8x_LB_dev=0
parameters cmim16acc_dev=0
parameters matching_dev=0
parameters rvt_dev=0
parameters eg_dev=0
parameters lsd_dev=0
parameters dsw_dev=0
parameters dsv_dev=0
parameters lsl_dev=0
parameters lsp_dev=0
parameters lsv_dev=0
parameters egncap_dev=0
parameters egpcap_dev=0
parameters rpolyp_dev=0
parameters rpolyh_dev=0
parameters rndiff_dev=0
parameters rnwell_dev=0
parameters diode_dev=0
parameters rmetal_dev=0
parameters lvt_dev=0
parameters eglvt_dev=0
parameters grhcdsti_dev=0
parameters grhcdgated_dev=0
parameters hcdgated_dev=0
parameters hcdsti_dev=0
parameters rvtnfetsb_dev=0
parameters egnfetsb_dev=0
parameters sblkndres_dev=0
parameters sblkpdres_dev=0
parameters hlvt_dev=0
parameters dsx_dev=0
parameters egext_dev=0
parameters cmom_rf_custom_dev=0
parameters veriloga_dev=0
// ------------------------------------------------------
// Global Flags Definition
// ------------------------------------------------------
parameters gflag__noisedev__lvt__cmos028fdsoi = 0
parameters gflag__noisedev__rvt__cmos028fdsoi = 0
parameters gflag__noisedev__eg__cmos028fdsoi = 0
parameters gflag__noisedev__hlvt__cmos028fdsoi = 0
parameters gflag__noisedev__eglvt__cmos028fdsoi = 0
// ------------------------------------------------------
// SOA Flags Definition
// ------------------------------------------------------
parameters grhcdsti_soa = 1
parameters egpcap_soa = 1
parameters cplate_soa = 1
parameters cmom_6u1x_2t8x_lb_soa = 1
parameters npnv_soa = 1
parameters lsl_soa = 1
parameters eg_soa = 1
parameters driftotp_soa = 1
parameters hcdgated_soa = 1
parameters pnpv_soa = 1
parameters cmom_5u1x_2t8x_lb_wo_via_soa = 1
parameters dsv_soa = 1
parameters egext_soa = 1
parameters grhcdgated_soa = 1
parameters cmom_6u1x_2t8x_lb_wo_via_soa = 1
parameters rpolyp_soa = 1
parameters lvt_soa = 1
parameters dsw_soa = 1
parameters egnfetsb_soa = 1
parameters lsp_soa = 1
parameters dsx_soa = 1
parameters cmom_5u1x_1t8x_lb_soa = 1
parameters cmom_5u1x_2t8x_lb_soa = 1
parameters rndiff_soa = 1
parameters cmom_6u1x_2u2x_2t8x_lb_soa = 1
parameters eglvt_soa = 1
parameters lsd_soa = 1
parameters cmom_5u1x_1t8x_lb_wo_via_soa = 1
parameters rnwell_soa = 1
parameters rvt_soa = 1
parameters cmim16acc_soa = 1
parameters lsv_soa = 1
parameters diode_soa = 1
parameters cmom_6u1x_2u2x_2t8x_lb_wo_via_soa = 1
parameters cmom_rf_custom_soa = 1
parameters rpolyh_soa = 1
parameters hlvt_soa = 1
parameters rvtnfetsb_soa = 1
parameters egncap_soa = 1
parameters hcdsti_soa = 1
parameters soa_modeling = 1
parameters soa_nonfunctionnal = 1
parameters soa_outofprocess = 1
parameters soa_reliability = 1
// ------------------------------------------------------
// Models Library Files References
// ------------------------------------------------------
include "$PDKITROOT/DATA/MODELS/SPECTRE/CORNERS/common_beol.scs" section=TT
include "$PDKITROOT/DATA/MODELS/SPECTRE/CORNERS/common_feol.scs" section=TT
include "$PDKITROOT/DATA/MODELS/SPECTRE/CORNERS/common_fet.scs" section=TT
include "$PDKITROOT/DATA/MODELS/SPECTRE/CORNERS/common_varactor.scs" section=TYP
include "$PDKITROOT/DATA/MODELS/SPECTRE/CORNERS/common_varind.scs" section=TYP
include "$PDKITROOT/DATA/MODELS/SPECTRE/CORNERS/common_cmim16acc.scs" section=typ
include "$PDKITROOT/DATA/MODELS/SPECTRE/CORNERS/common_esd.scs" section=TT
include "$PDKITROOT/DATA/MODELS/SPECTRE/CORNERS/cmom_5u1x_2t8x_lb.scs" section=TT
include "$PDKITROOT/DATA/MODELS/SPECTRE/CORNERS/cmom_5u1x_2t8x_lb_wo_via.scs" section=TT
include "$PDKITROOT/DATA/MODELS/SPECTRE/CORNERS/cmom_6u1x_2t8x_lb.scs" section=TT
include "$PDKITROOT/DATA/MODELS/SPECTRE/CORNERS/cmom_6u1x_2t8x_lb_wo_via.scs" section=TT
include "$PDKITROOT/DATA/MODELS/SPECTRE/CORNERS/cmom_6u1x_2u2x_2t8x_lb.scs" section=TT
include "$PDKITROOT/DATA/MODELS/SPECTRE/CORNERS/cmom_6u1x_2u2x_2t8x_lb_wo_via.scs" section=TT
include "$PDKITROOT/DATA/MODELS/SPECTRE/CORNERS/cmom_5u1x_1t8x_lb.scs" section=TT
include "$PDKITROOT/DATA/MODELS/SPECTRE/CORNERS/cmom_5u1x_1t8x_lb_wo_via.scs" section=TT
include "$PDKITROOT/DATA/MODELS/SPECTRE/CORNERS/driftotp.scs" section=TT
include "$PDKITROOT/DATA/MODELS/SPECTRE/CORNERS/cvar_eg.scs" section=TYP
include "$PDKITROOT/DATA/MODELS/SPECTRE/CORNERS/pnpv.scs" section=typ
include "$PDKITROOT/DATA/MODELS/SPECTRE/CORNERS/npnv.scs" section=typ
include "$PDKITROOT/DATA/MODELS/SPECTRE/CORNERS/ind_lohq_5U1x_2T8x_LB.scs" section=TYP
include "$PDKITROOT/DATA/MODELS/SPECTRE/CORNERS/ind_hq_5U1x_2T8x_LB.scs" section=TYP
include "$PDKITROOT/DATA/MODELS/SPECTRE/CORNERS/ind_lohq_6U1x_2T8x_LB.scs" section=TYP
include "$PDKITROOT/DATA/MODELS/SPECTRE/CORNERS/ind_hq_6U1x_2T8x_LB.scs" section=TYP
include "$PDKITROOT/DATA/MODELS/SPECTRE/CORNERS/ind_lohq_6U1x_2U2x_2T8x_LB.scs" section=TYP
include "$PDKITROOT/DATA/MODELS/SPECTRE/CORNERS/ind_hq_6U1x_2U2x_2T8x_LB.scs" section=TYP
include "$PDKITROOT/DATA/MODELS/SPECTRE/CORNERS/cmim16acc.scs" section=typ
include "$PDKITROOT/DATA/MODELS/SPECTRE/CORNERS/matching.scs" section=XYPOS
include "$PDKITROOT/DATA/MODELS/SPECTRE/CORNERS/rvt.scs" section=TT
include "$PDKITROOT/DATA/MODELS/SPECTRE/CORNERS/eg.scs" section=TT
include "$PDKITROOT/DATA/MODELS/SPECTRE/CORNERS/lsd.scs" section=TT
include "$PDKITROOT/DATA/MODELS/SPECTRE/CORNERS/dsw.scs" section=TT
include "$PDKITROOT/DATA/MODELS/SPECTRE/CORNERS/dsv.scs" section=TT
include "$PDKITROOT/DATA/MODELS/SPECTRE/CORNERS/lsl.scs" section=TT
include "$PDKITROOT/DATA/MODELS/SPECTRE/CORNERS/lsp.scs" section=TT
include "$PDKITROOT/DATA/MODELS/SPECTRE/CORNERS/lsv.scs" section=TT
include "$PDKITROOT/DATA/MODELS/SPECTRE/CORNERS/egncap.scs" section=TT
include "$PDKITROOT/DATA/MODELS/SPECTRE/CORNERS/egpcap.scs" section=TT
include "$PDKITROOT/DATA/MODELS/SPECTRE/CORNERS/rpolyp.scs" section=TT
include "$PDKITROOT/DATA/MODELS/SPECTRE/CORNERS/rpolyh.scs" section=TT
include "$PDKITROOT/DATA/MODELS/SPECTRE/CORNERS/rndiff.scs" section=TT
include "$PDKITROOT/DATA/MODELS/SPECTRE/CORNERS/rnwell.scs" section=TT
include "$PDKITROOT/DATA/MODELS/SPECTRE/CORNERS/diode.scs" section=typ
include "$PDKITROOT/DATA/MODELS/SPECTRE/CORNERS/rmetal.scs" section=TT
include "$PDKITROOT/DATA/MODELS/SPECTRE/CORNERS/lvt.scs" section=TT
include "$PDKITROOT/DATA/MODELS/SPECTRE/CORNERS/eglvt.scs" section=TT
include "$PDKITROOT/DATA/MODELS/SPECTRE/CORNERS/grhcdsti.scs" section=TT
include "$PDKITROOT/DATA/MODELS/SPECTRE/CORNERS/grhcdgated.scs" section=TT
include "$PDKITROOT/DATA/MODELS/SPECTRE/CORNERS/hcdgated.scs" section=TT
include "$PDKITROOT/DATA/MODELS/SPECTRE/CORNERS/hcdsti.scs" section=TT
include "$PDKITROOT/DATA/MODELS/SPECTRE/CORNERS/rvtnfetsb.scs" section=TT
include "$PDKITROOT/DATA/MODELS/SPECTRE/CORNERS/egnfetsb.scs" section=TT
include "$PDKITROOT/DATA/MODELS/SPECTRE/CORNERS/sblkndres.scs" section=TT
include "$PDKITROOT/DATA/MODELS/SPECTRE/CORNERS/sblkpdres.scs" section=TT
include "$PDKITROOT/DATA/MODELS/SPECTRE/CORNERS/hlvt.scs" section=TT
include "$PDKITROOT/DATA/MODELS/SPECTRE/CORNERS/dsx.scs" section=TT
include "$PDKITROOT/DATA/MODELS/SPECTRE/CORNERS/egext.scs" section=TT
include "$PDKITROOT/DATA/MODELS/SPECTRE/CORNERS/cmom_rf_custom.scs" section=TT
include "$PDKITROOT/DATA/MODELS/SPECTRE/CORNERS/veriloga.scs" section=typ
